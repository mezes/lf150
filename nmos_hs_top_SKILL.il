pcDefinePCell(list(ddGetObj("lf150_top") "nmos_hs_top_SKILL" "layout")
    ((Fingers int 2)
	(Length float 1)
	(finger_width float 4)
    )
    let((Fingers Length pcHorStretch30 pcHorStretch30offset Length1
	    Length1offset Length2 Length2offset Length3 Length3offset
	    finger_width finger_width4 finger_width4offset pcMember pcStretchGroup
	    stretchOffsetX stretchOffsetY pcLib pcMaster pcInst
	    pcTerm pcPin pcPinName pcNet pcTermNet
	    pcNetName pcTermNetName pcMosaicInst pcParameters pcParamProp
	    pcStep pcStepX pcStepY pcRepeat pcRepeatX
	    pcRepeatY pcIndexX pcIndexY pcLayer pcPurpose
	    pcLabelText pcLabelHeight pcPropText pcParamText pcCoords
	    pcPathWidth pcPolygonMargin
	)
	(pcLib = (pcCellView~>lib))
	(pcParameters = ((pcCellView~>parameters)~>value))
	(pcParamProp = car(exists(prop pcParameters
		    ((prop~>name) == "Fingers")
		)
	    ))
	(Fingers = (pcParamProp~>value))
	if( ((pcParamProp~>valueType) == "boolean")
	    (Fingers = (Fingers == "TRUE"))
	)
	(pcParamProp = car(exists(prop pcParameters
		    ((prop~>name) == "Length")
		)
	    ))
	(Length = (pcParamProp~>value))
	if( ((pcParamProp~>valueType) == "boolean")
	    (Length = (Length == "TRUE"))
	)
	(pcParamProp = car(exists(prop pcParameters
		    ((prop~>name) == "finger_width")
		)
	    ))
	(finger_width = (pcParamProp~>value))
	if( ((pcParamProp~>valueType) == "boolean")
	    (finger_width = (finger_width == "TRUE"))
	)
	(pcHorStretch30 = (((Fingers - 1) * 0.42) + (Fingers * Length)))
	(Length1 = (1.16 + (Length * 2)))
	(Length2 = (1.16 + (2 * Length)))
	(Length3 = Length)
	(finger_width4 = finger_width)
	(pcHorStretch30offset = (pcHorStretch30 - 0.15))
	(Length1offset = (Length1 - 0.32))
	(Length2offset = (Length2 - 0.32))
	if( (Length3 < 0.15)
	    then
	    (Length3 = 0.15)
	)
	if( (Length3 > 20)
	    then
	    (Length3 = 20.0)
	)
	(Length3offset = (Length3 - 0.15))
	if( (finger_width4 < 0.32)
	    then
	    (finger_width4 = 0.32)
	)
	(finger_width4offset = (finger_width4 - 0.32))
	dbReplaceProp(pcCellView "viewSubType" "string" "maskLayoutParamCell")
	dbReplaceProp(pcCellView "pin#" "int" 16)
	dbReplaceProp(pcCellView "function" "string" "transistor")
	(pcRepeat = (pcRepeatX = (pcRepeatY = 1.0)))
	(pcStep = (pcStepX = (pcStepY = 0.0)))
	(pcStep = (pcStepX = car(errset((0.84 + (2 * Length))))))
	(pcRepeat = (pcRepeatX = (((Fingers - 1) / 2) + 1)))
	(pcStep = (pcStepX = (0.84 + (2 * Length))))
	(pcIndexY = 0)
	for( pcIndexX 0 (fix(pcRepeatX) - 1)
	    nil
	    if( (Fingers > 2)
		then
		(pcLayer = 133)
		(pcPurpose = "drawing")
		(pcInst = dbCreateRect(pcCellView
			list(pcLayer pcPurpose)
			list(((0.2 + Length3offset + (pcIndexX * pcStepX)):(0.22 + finger_width4offset))
			    ((0.52 + Length3offset + (pcIndexX * pcStepX)):(0.5600000000000001 + finger_width4offset))
			)
		    ))
		dbReplaceProp(pcInst "lxStickyNet" "boolean" t)
	    )
	)
	(pcRepeat = (pcRepeatX = (pcRepeatY = 1.0)))
	(pcStep = (pcStepX = (pcStepY = 0.0)))
	(pcStep = (pcStepX = car(errset((0.84 + (2 * Length))))))
	(pcRepeat = (pcRepeatX = (((Fingers - 1) / 2) + 1)))
	(pcStep = (pcStepX = (0.84 + (2 * Length))))
	(pcIndexY = 0)
	for( pcIndexX 0 (fix(pcRepeatX) - 1)
	    nil
	    (pcLayer = 133)
	    (pcPurpose = "drawing")
	    (pcInst = dbCreateRect(pcCellView
		    list(pcLayer pcPurpose)
		    list(((0.2 + Length3offset + (pcIndexX * pcStepX)):0.0)
			((0.52 + Length3offset + (pcIndexX * pcStepX)):(0.32 + finger_width4offset))
		    )
		))
	    dbReplaceProp(pcInst "lxStickyNet" "boolean" t)
	)
	(pcRepeat = (pcRepeatX = (pcRepeatY = 1.0)))
	(pcStep = (pcStepX = (pcStepY = 0.0)))
	(pcStep = (pcStepX = car(errset((0.84 + (2 * Length))))))
	(pcRepeat = (pcRepeatX = ((Fingers / 2) + 1)))
	(pcStep = (pcStepX = (0.84 + (2 * Length))))
	(pcIndexY = 0)
	for( pcIndexX 0 (fix(pcRepeatX) - 1)
	    nil
	    (pcLayer = 400)
	    (pcPurpose = "drawing")
	    (pcInst = dbCreateRect(pcCellView
		    list(pcLayer pcPurpose)
		    list(((-0.37 + (pcIndexX * pcStepX)):0.0)
			((-0.05 + (pcIndexX * pcStepX)):(0.32 + finger_width4offset))
		    )
		))
	    dbReplaceProp(pcInst "lxStickyNet" "boolean" t)
	)
	(pcRepeat = (pcRepeatX = (pcRepeatY = 1.0)))
	(pcStep = (pcStepX = (pcStepY = 0.0)))
	(pcStep = (pcStepX = car(errset((0.84 + (2 * Length))))))
	(pcRepeat = (pcRepeatX = (Fingers / 2)))
	(pcStep = (pcStepX = (0.84 + (2 * Length))))
	(pcIndexY = 0)
	for( pcIndexX 0 (fix(pcRepeatX) - 1)
	    nil
	    if( (Fingers > 1)
		then
		(pcLayer = 133)
		(pcPurpose = "drawing")
		(pcInst = dbCreateRect(pcCellView
			list(pcLayer pcPurpose)
			list(((-0.37 + (pcIndexX * pcStepX)):-0.54)
			    ((-0.05 + Length1offset + (pcIndexX * pcStepX)):-0.24)
			)
		    ))
		dbReplaceProp(pcInst "lxStickyNet" "boolean" t)
	    )
	)
	(pcRepeat = (pcRepeatX = (pcRepeatY = 1.0)))
	(pcStep = (pcStepX = (pcStepY = 0.0)))
	(pcStep = (pcStepX = car(errset(0.48))))
	(pcRepeat = (pcRepeatX = (((Fingers * (Length + 0.42)) - 0.09) / 0.48)))
	(pcStep = (pcStepX = 0.48))
	(pcIndexY = 0)
	for( pcIndexX 0 (fix(pcRepeatX) - 1)
	    nil
	    if( (Fingers > 2)
		then
		(pcLayer = 135)
		(pcPurpose = "drawing")
		(pcInst = dbCreateRect(pcCellView
			list(pcLayer pcPurpose)
			list(((-0.02 + (pcIndexX * pcStepX)):(1.13 + finger_width4offset))
			    ((0.16 + (pcIndexX * pcStepX)):(1.31 + finger_width4offset))
			)
		    ))
	    )
	)
	(pcRepeat = (pcRepeatX = (pcRepeatY = 1.0)))
	(pcStep = (pcStepX = (pcStepY = 0.0)))
	(pcStep = (pcStepX = car(errset((0.84 + (2 * Length))))))
	(pcRepeat = (pcRepeatX = (((Fingers - 1) / 2) + 1)))
	(pcStep = (pcStepX = (0.84 + (2 * Length))))
	(pcIndexY = 0)
	for( pcIndexX 0 (fix(pcRepeatX) - 1)
	    nil
	    (pcLayer = 400)
	    (pcPurpose = "drawing")
	    (pcInst = dbCreateRect(pcCellView
		    list(pcLayer pcPurpose)
		    list(((0.2 + Length3offset + (pcIndexX * pcStepX)):0.0)
			((0.52 + Length3offset + (pcIndexX * pcStepX)):(0.32 + finger_width4offset))
		    )
		))
	    dbReplaceProp(pcInst "lxStickyNet" "boolean" t)
	)
	(pcRepeat = (pcRepeatX = (pcRepeatY = 1.0)))
	(pcStep = (pcStepX = (pcStepY = 0.0)))
	(pcStep = (pcStepX = car(errset(0.48))))
	(pcRepeat = (pcRepeatX = (((Fingers * (Length + 0.42)) - 0.09) / 0.48)))
	(pcStep = (pcStepX = 0.48))
	(pcIndexY = 0)
	for( pcIndexX 0 (fix(pcRepeatX) - 1)
	    nil
	    if( (Fingers < 3)
		then
		(pcLayer = 135)
		(pcPurpose = "drawing")
		(pcInst = dbCreateRect(pcCellView
			list(pcLayer pcPurpose)
			list(((-0.02 + (pcIndexX * pcStepX)):(0.59 + finger_width4offset))
			    ((0.16 + (pcIndexX * pcStepX)):(0.77 + finger_width4offset))
			)
		    ))
	    )
	)
	(pcRepeat = (pcRepeatX = (pcRepeatY = 1.0)))
	(pcStep = (pcStepX = (pcStepY = 0.0)))
	(pcStep = (pcStepX = car(errset((0.84 + (2 * Length))))))
	(pcRepeat = (pcRepeatX = ((Fingers / 2) + 1)))
	(pcStep = (pcStepX = (0.84 + (2 * Length))))
	(pcIndexY = 0)
	for( pcIndexX 0 (fix(pcRepeatX) - 1)
	    nil
	    (pcLayer = 133)
	    (pcPurpose = "drawing")
	    (pcInst = dbCreateRect(pcCellView
		    list(pcLayer pcPurpose)
		    list(((-0.37 + (pcIndexX * pcStepX)):0.0)
			((-0.05 + (pcIndexX * pcStepX)):(0.32 + finger_width4offset))
		    )
		))
	    dbReplaceProp(pcInst "lxStickyNet" "boolean" t)
	)
	(pcRepeat = (pcRepeatX = (pcRepeatY = 1.0)))
	(pcStep = (pcStepX = (pcStepY = 0.0)))
	(pcStep = (pcStepX = car(errset((0.42 + Length)))))
	(pcRepeat = (pcRepeatX = Fingers))
	(pcStep = (pcStepX = (0.42 + Length)))
	(pcIndexY = 0)
	for( pcIndexX 0 (fix(pcRepeatX) - 1)
	    nil
	    if( (Fingers > 2)
		then
		(pcLayer = 425)
		(pcPurpose = "drawing")
		(pcInst = dbCreateRect(pcCellView
			list(pcLayer pcPurpose)
			list(((-0.08 + (pcIndexX * pcStepX)):(1.07 + finger_width4offset))
			    ((0.22 + Length3offset + (pcIndexX * pcStepX)):(1.37 + finger_width4offset))
			)
		    ))
		dbReplaceProp(pcInst "lxStickyNet" "boolean" t)
	    )
	    if( (Fingers > 2)
		then
		(pcLayer = 425)
		(pcPurpose = "drawing")
		(pcInst = dbCreateRect(pcCellView
			list(pcLayer pcPurpose)
			list(((0.0 + (pcIndexX * pcStepX)):-0.24)
			    ((0.15 + Length3offset + (pcIndexX * pcStepX)):(1.07 + finger_width4offset))
			)
		    ))
		dbReplaceProp(pcInst "lxStickyNet" "boolean" t)
	    )
	)
	(pcRepeat = (pcRepeatX = (pcRepeatY = 1.0)))
	(pcStep = (pcStepX = (pcStepY = 0.0)))
	(pcStep = (pcStepX = car(errset((0.42 + Length)))))
	(pcRepeat = (pcRepeatX = Fingers))
	(pcStep = (pcStepX = (0.42 + Length)))
	(pcIndexY = 0)
	for( pcIndexX 0 (fix(pcRepeatX) - 1)
	    nil
	    if( (Fingers > 2)
		then
		(pcLayer = 133)
		(pcPurpose = "drawing")
		(pcInst = dbCreateRect(pcCellView
			list(pcLayer pcPurpose)
			list(((-0.06 + (pcIndexX * pcStepX)):(1.1 + finger_width4offset))
			    ((0.2 + Length3offset + (pcIndexX * pcStepX)):(1.34 + finger_width4offset))
			)
		    ))
		dbReplaceProp(pcInst "lxStickyNet" "boolean" t)
	    )
	)
	(pcRepeat = (pcRepeatX = (pcRepeatY = 1.0)))
	(pcStep = (pcStepX = (pcStepY = 0.0)))
	(pcStep = (pcStepX = car(errset((0.84 + (2 * Length))))))
	(pcRepeat = (pcRepeatX = ((Fingers / 2) + 1)))
	(pcStep = (pcStepX = (0.84 + (2 * Length))))
	(pcIndexY = 0)
	for( pcIndexX 0 (fix(pcRepeatX) - 1)
	    nil
	    if( (Fingers > 1)
		then
		(pcLayer = 133)
		(pcPurpose = "drawing")
		(pcInst = dbCreateRect(pcCellView
			list(pcLayer pcPurpose)
			list(((-0.37 + (pcIndexX * pcStepX)):-0.3)
			    ((-0.05 + (pcIndexX * pcStepX)):0.04)
			)
		    ))
		dbReplaceProp(pcInst "lxStickyNet" "boolean" t)
	    )
	)
	(pcRepeat = (pcRepeatX = (pcRepeatY = 1.0)))
	(pcStep = (pcStepX = (pcStepY = 0.0)))
	(pcStep = (pcStepX = car(errset((0.84 + (2 * Length))))))
	(pcRepeat = (pcRepeatX = ((Fingers - 1) / 2)))
	(pcStep = (pcStepX = (0.84 + (2 * Length))))
	(pcIndexY = 0)
	for( pcIndexX 0 (fix(pcRepeatX) - 1)
	    nil
	    if( (Fingers > 2)
		then
		(pcLayer = 133)
		(pcPurpose = "drawing")
		(pcInst = dbCreateRect(pcCellView
			list(pcLayer pcPurpose)
			list(((0.2 + Length3offset + (pcIndexX * pcStepX)):(0.5600000000000001 + finger_width4offset))
			    ((0.52 + Length2offset + Length3offset + (pcIndexX * pcStepX)):(0.86 + finger_width4offset))
			)
		    ))
		dbReplaceProp(pcInst "lxStickyNet" "boolean" t)
	    )
	)
	(pcRepeat = (pcRepeatX = (pcRepeatY = 1.0)))
	(pcStep = (pcStepX = (pcStepY = 0.0)))
	(pcStep = (pcStepX = car(errset((0.42 + Length)))))
	(pcRepeat = (pcRepeatX = (Fingers - 1)))
	(pcStep = (pcStepX = (0.42 + Length)))
	(pcIndexY = 0)
	for( pcIndexX 0 (fix(pcRepeatX) - 1)
	    nil
	    if( (Fingers > 2)
		then
		(pcLayer = 425)
		(pcPurpose = "drawing")
		(pcInst = dbCreateRect(pcCellView
			list(pcLayer pcPurpose)
			list(((0.22 + Length3offset + (pcIndexX * pcStepX)):(1.07 + finger_width4offset))
			    ((0.49 + Length3offset + (pcIndexX * pcStepX)):(1.37 + finger_width4offset))
			)
		    ))
		dbReplaceProp(pcInst "lxStickyNet" "boolean" t)
	    )
	)
	(pcRepeat = (pcRepeatX = (pcRepeatY = 1.0)))
	(pcStep = (pcStepX = (pcStepY = 0.0)))
	(pcStep = (pcStepX = car(errset((0.42 + Length)))))
	(pcRepeat = (pcRepeatX = Fingers))
	(pcStep = (pcStepX = (0.42 + Length)))
	(pcIndexY = 0)
	for( pcIndexX 0 (fix(pcRepeatX) - 1)
	    nil
	    if( (Fingers < 3)
		then
		(pcLayer = 133)
		(pcPurpose = "drawing")
		(pcInst = dbCreateRect(pcCellView
			list(pcLayer pcPurpose)
			list(((-0.06 + (pcIndexX * pcStepX)):(0.5600000000000001 + finger_width4offset))
			    ((0.2 + Length3offset + (pcIndexX * pcStepX)):(0.8 + finger_width4offset))
			)
		    ))
		dbReplaceProp(pcInst "lxStickyNet" "boolean" t)
	    )
	    (pcLayer = 400)
	    (pcPurpose = "drawing")
	    (pcInst = dbCreateRect(pcCellView
		    list(pcLayer pcPurpose)
		    list(((-0.05 + (pcIndexX * pcStepX)):0.0)
			((0.0 + (pcIndexX * pcStepX)):(0.32 + finger_width4offset))
		    )
		))
	    dbReplaceProp(pcInst "lxStickyNet" "boolean" t)
	    (pcLayer = 400)
	    (pcPurpose = "drawing")
	    (pcInst = dbCreateRect(pcCellView
		    list(pcLayer pcPurpose)
		    list(((0.0 + (pcIndexX * pcStepX)):0.0)
			((0.15 + Length3offset + (pcIndexX * pcStepX)):(0.32 + finger_width4offset))
		    )
		))
	    (pcLayer = 400)
	    (pcPurpose = "drawing")
	    (pcInst = dbCreateRect(pcCellView
		    list(pcLayer pcPurpose)
		    list(((0.15 + Length3offset + (pcIndexX * pcStepX)):0.0)
			((0.2 + Length3offset + (pcIndexX * pcStepX)):(0.32 + finger_width4offset))
		    )
		))
	    dbReplaceProp(pcInst "lxStickyNet" "boolean" t)
	    if( (Fingers < 3)
		then
		(pcLayer = 425)
		(pcPurpose = "drawing")
		(pcInst = dbCreateRect(pcCellView
			list(pcLayer pcPurpose)
			list(((-0.08 + (pcIndexX * pcStepX)):(0.53 + finger_width4offset))
			    ((0.22 + Length3offset + (pcIndexX * pcStepX)):(0.83 + finger_width4offset))
			)
		    ))
		dbReplaceProp(pcInst "lxStickyNet" "boolean" t)
	    )
	    if( (Fingers < 3)
		then
		(pcLayer = 425)
		(pcPurpose = "drawing")
		(pcInst = dbCreateRect(pcCellView
			list(pcLayer pcPurpose)
			list(((0.0 + (pcIndexX * pcStepX)):-0.24)
			    ((0.15 + Length3offset + (pcIndexX * pcStepX)):(0.53 + finger_width4offset))
			)
		    ))
		dbReplaceProp(pcInst "lxStickyNet" "boolean" t)
	    )
	)
	(pcRepeat = (pcRepeatX = (pcRepeatY = 1.0)))
	(pcStep = (pcStepX = (pcStepY = 0.0)))
	(pcStepX = car(errset((0.84 + (2 * Length)))))
	(pcStepY = car(errset(0.48)))
	(pcRepeatX = (((Fingers - 1) / 2) + 1))
	(pcRepeatY = ((finger_width + 0.16) / 0.48))
	(pcStepX = (0.84 + (2 * Length)))
	(pcStepY = 0.48)
	for( pcIndexX 0 (fix(pcRepeatX) - 1)
	    for( pcIndexY 0 (fix(pcRepeatY) - 1)
		nil
		(pcLayer = 135)
		(pcPurpose = "drawing")
		(pcInst = dbCreateRect(pcCellView
			list(pcLayer pcPurpose)
			list(((0.27 + Length3offset + (pcIndexX * pcStepX)):(0.04 + (pcIndexY * pcStepY)))
			    ((0.45 + Length3offset + (pcIndexX * pcStepX)):(0.22 + (pcIndexY * pcStepY)))
			)
		    ))
	    )
	)
	(pcRepeat = (pcRepeatX = (pcRepeatY = 1.0)))
	(pcStep = (pcStepX = (pcStepY = 0.0)))
	(pcStep = (pcStepX = car(errset((0.42 + Length)))))
	(pcRepeat = (pcRepeatX = (Fingers - 1)))
	(pcStep = (pcStepX = (0.42 + Length)))
	(pcIndexY = 0)
	for( pcIndexX 0 (fix(pcRepeatX) - 1)
	    nil
	    if( (Fingers > 2)
		then
		(pcLayer = 133)
		(pcPurpose = "drawing")
		(pcInst = dbCreateRect(pcCellView
			list(pcLayer pcPurpose)
			list(((0.2 + Length3offset + (pcIndexX * pcStepX)):(1.1 + finger_width4offset))
			    ((0.51 + Length3offset + (pcIndexX * pcStepX)):(1.34 + finger_width4offset))
			)
		    ))
		dbReplaceProp(pcInst "lxStickyNet" "boolean" t)
	    )
	)
	(pcRepeat = (pcRepeatX = (pcRepeatY = 1.0)))
	(pcStep = (pcStepX = (pcStepY = 0.0)))
	(pcStepX = car(errset((0.84 + (2 * Length)))))
	(pcStepY = car(errset(0.48)))
	(pcRepeatX = ((Fingers / 2) + 1))
	(pcRepeatY = ((finger_width + 0.16) / 0.48))
	(pcStepX = (0.84 + (2 * Length)))
	(pcStepY = 0.48)
	for( pcIndexX 0 (fix(pcRepeatX) - 1)
	    for( pcIndexY 0 (fix(pcRepeatY) - 1)
		nil
		(pcLayer = 135)
		(pcPurpose = "drawing")
		(pcInst = dbCreateRect(pcCellView
			list(pcLayer pcPurpose)
			list(((-0.3 + (pcIndexX * pcStepX)):(0.04 + (pcIndexY * pcStepY)))
			    ((-0.12 + (pcIndexX * pcStepX)):(0.22 + (pcIndexY * pcStepY)))
			)
		    ))
	    )
	)
	(pcRepeat = (pcRepeatX = (pcRepeatY = 1.0)))
	(pcStep = (pcStepX = (pcStepY = 0.0)))
	(pcStep = (pcStepX = car(errset((0.42 + Length)))))
	(pcRepeat = (pcRepeatX = Fingers))
	(pcStep = (pcStepX = (0.42 + Length)))
	(pcIndexY = 0)
	for( pcIndexX 0 (fix(pcRepeatX) - 1)
	    nil
	    if( (Fingers < 3)
		then
		(pcLayer = 399)
		(pcPurpose = "drawing")
		(pcInst = dbCreateRect(pcCellView
			list(pcLayer pcPurpose)
			list(((0.0 + (pcIndexX * pcStepX)):-0.24)
			    ((0.15 + Length3offset + (pcIndexX * pcStepX)):(0.53 + finger_width4offset))
			)
		    ))
	    )
	    if( (Fingers < 3)
		then
		(pcLayer = 399)
		(pcPurpose = "drawing")
		(pcInst = dbCreateRect(pcCellView
			list(pcLayer pcPurpose)
			list(((-0.08 + (pcIndexX * pcStepX)):(0.53 + finger_width4offset))
			    ((0.22 + Length3offset + (pcIndexX * pcStepX)):(0.83 + finger_width4offset))
			)
		    ))
	    )
	    if( (Fingers > 2)
		then
		(pcLayer = 399)
		(pcPurpose = "drawing")
		(pcInst = dbCreateRect(pcCellView
			list(pcLayer pcPurpose)
			list(((-0.08 + (pcIndexX * pcStepX)):(1.07 + finger_width4offset))
			    ((0.22 + Length3offset + (pcIndexX * pcStepX)):(1.37 + finger_width4offset))
			)
		    ))
	    )
	    if( (Fingers > 2)
		then
		(pcLayer = 399)
		(pcPurpose = "drawing")
		(pcInst = dbCreateRect(pcCellView
			list(pcLayer pcPurpose)
			list(((0.0 + (pcIndexX * pcStepX)):-0.24)
			    ((0.15 + Length3offset + (pcIndexX * pcStepX)):(1.07 + finger_width4offset))
			)
		    ))
	    )
	)
	(pcRepeat = (pcRepeatX = (pcRepeatY = 1.0)))
	(pcStep = (pcStepX = (pcStepY = 0.0)))
	(pcStep = (pcStepX = car(errset((0.42 + Length)))))
	(pcRepeat = (pcRepeatX = (Fingers - 1)))
	(pcStep = (pcStepX = (0.42 + Length)))
	(pcIndexY = 0)
	for( pcIndexX 0 (fix(pcRepeatX) - 1)
	    nil
	    if( (Fingers > 2)
		then
		(pcLayer = 399)
		(pcPurpose = "drawing")
		(pcInst = dbCreateRect(pcCellView
			list(pcLayer pcPurpose)
			list(((0.22 + Length3offset + (pcIndexX * pcStepX)):(1.07 + finger_width4offset))
			    ((0.49 + Length3offset + (pcIndexX * pcStepX)):(1.37 + finger_width4offset))
			)
		    ))
	    )
	)
	(pcNetName = "S")
	(pcTermNet = dbMakeNet(pcCellView pcNetName nil))
	if( !(pcTerm = dbFindTermByName(pcCellView pcNetName))
	    then
	    (pcTerm = dbCreateTerm(pcTermNet pcNetName "inputOutput" 0))
	)
	(pcLayer = 133)
	(pcPurpose = "drawing")
	(pcInst = dbCreateRect(pcCellView
		list(pcLayer pcPurpose)
		list((-0.28:0.06)
		    (-0.14:0.2)
		)
	    ))
	(pcPin = dbCreatePin(pcTermNet pcInst "P__5"))
	setSGq(pcPin
	    '("top" "bottom" "left" "right") accessDir
	)
	if( !(pcTerm~>pins)
	    then
	    dbDeleteObject(pcTerm)
	    if( (!(pcTermNet~>figs) && !(pcTermNet~>instTerms))
		then
		dbDeleteObject(pcTermNet)
	    )
	)
	(pcNetName = "D")
	(pcTermNet = dbMakeNet(pcCellView pcNetName nil))
	if( !(pcTerm = dbFindTermByName(pcCellView pcNetName))
	    then
	    (pcTerm = dbCreateTerm(pcTermNet pcNetName "inputOutput" 0))
	)
	(pcLayer = 133)
	(pcPurpose = "drawing")
	(pcInst = dbCreateRect(pcCellView
		list(pcLayer pcPurpose)
		list(((0.29 + Length3offset):0.06)
		    ((0.43 + Length3offset):0.2)
		)
	    ))
	(pcPin = dbCreatePin(pcTermNet pcInst "P__6"))
	setSGq(pcPin
	    '("top" "bottom" "left" "right") accessDir
	)
	if( !(pcTerm~>pins)
	    then
	    dbDeleteObject(pcTerm)
	    if( (!(pcTermNet~>figs) && !(pcTermNet~>instTerms))
		then
		dbDeleteObject(pcTermNet)
	    )
	)
	(pcNetName = "G")
	(pcTermNet = dbMakeNet(pcCellView pcNetName nil))
	if( !(pcTerm = dbFindTermByName(pcCellView pcNetName))
	    then
	    (pcTerm = dbCreateTerm(pcTermNet pcNetName "inputOutput" 0))
	)
	if( (Fingers > 2)
	    then
	    (pcLayer = 133)
	    (pcPurpose = "drawing")
	    (pcInst = dbCreateRect(pcCellView
		    list(pcLayer pcPurpose)
		    list((0.0:(1.15 + finger_width4offset))
			(0.14:(1.29 + finger_width4offset))
		    )
		))
	    (pcPin = dbCreatePin(pcTermNet pcInst "P__4"))
	    setSGq(pcPin
		'("top" "bottom" "left" "right") accessDir
	    )
	)
	if( (Fingers < 3)
	    then
	    (pcLayer = 133)
	    (pcPurpose = "drawing")
	    (pcInst = dbCreateRect(pcCellView
		    list(pcLayer pcPurpose)
		    list((0.0:(0.61 + finger_width4offset))
			(0.14:(0.75 + finger_width4offset))
		    )
		))
	    (pcPin = dbCreatePin(pcTermNet pcInst "P__0"))
	    setSGq(pcPin
		'("top" "bottom" "left" "right") accessDir
	    )
	)
	if( !(pcTerm~>pins)
	    then
	    dbDeleteObject(pcTerm)
	    if( (!(pcTermNet~>figs) && !(pcTermNet~>instTerms))
		then
		dbDeleteObject(pcTermNet)
	    )
	)
	(pcNetName = "B")
	(pcTermNet = dbMakeNet(pcCellView pcNetName nil))
	if( !(pcTerm = dbFindTermByName(pcCellView pcNetName))
	    then
	    (pcTerm = dbCreateTerm(pcTermNet pcNetName "inputOutput" 0))
	)
	(pcLayer = 399)
	(pcPurpose = "drawing")
	(pcInst = dbCreateRect(pcCellView
		list(pcLayer pcPurpose)
		list((0.04:0.1)
		    (0.1:0.18)
		)
	    ))
	(pcPin = dbCreatePin(pcTermNet pcInst "P__1"))
	setSGq(pcPin
	    '("top" "bottom" "left" "right") accessDir
	)
	if( !(pcTerm~>pins)
	    then
	    dbDeleteObject(pcTerm)
	    if( (!(pcTermNet~>figs) && !(pcTermNet~>instTerms))
		then
		dbDeleteObject(pcTermNet)
	    )
	)
	(pcLayer = 435)
	(pcPurpose = "drawing")
	(pcInst = dbCreateRect(pcCellView
		list(pcLayer pcPurpose)
		list((-0.61:-0.32)
		    ((0.76 + pcHorStretch30offset):(0.64 + finger_width4offset))
		)
	    ))
	if( (Fingers == 2)
	    then
	    (pcLayer = 425)
	    (pcPurpose = "drawing")
	    (pcInst = dbCreateRect(pcCellView
		    list(pcLayer pcPurpose)
		    list(((0.22 + Length3offset):(0.53 + finger_width4offset))
			((0.49 + Length3offset):(0.83 + finger_width4offset))
		    )
		))
	    dbReplaceProp(pcInst "lxStickyNet" "boolean" t)
	    dbAddFigToNet(pcInst
		(pcNet = dbMakeNet(pcCellView "G"))
	    )
	    set(concat("G") pcNet)
	)
	if( (Fingers == 2)
	    then
	    (pcLayer = 133)
	    (pcPurpose = "drawing")
	    (pcInst = dbCreateRect(pcCellView
		    list(pcLayer pcPurpose)
		    list(((0.2 + Length3offset):(0.5600000000000001 + finger_width4offset))
			((0.51 + Length3offset):(0.8 + finger_width4offset))
		    )
		))
	    dbReplaceProp(pcInst "lxStickyNet" "boolean" t)
	    dbAddFigToNet(pcInst
		(pcNet = dbMakeNet(pcCellView "G"))
	    )
	    set(concat("G") pcNet)
	)
	(pcLayer = 409)
	(pcPurpose = "drawing")
	(pcInst = dbCreateRect(pcCellView
		list(pcLayer pcPurpose)
		list((-0.53:-0.32)
		    ((0.68 + pcHorStretch30offset):(0.64 + finger_width4offset))
		)
	    ))
	(pcLayer = 441)
	(pcPurpose = "drawing")
	(pcInst = dbCreateRect(pcCellView
		list(pcLayer pcPurpose)
		list((-0.61:-0.24)
		    ((0.76 + pcHorStretch30offset):(0.5600000000000001 + finger_width4offset))
		)
	    ))
	if( (Fingers > 2)
	    then
	    (pcLayer = 422)
	    (pcPurpose = "drawing")
	    (pcInst = dbCreateRect(pcCellView
		    list(pcLayer pcPurpose)
		    list((-0.37:-0.24)
			((0.52 + pcHorStretch30offset):(1.37 + finger_width4offset))
		    )
		))
	)
	if( (Fingers < 3)
	    then
	    (pcLayer = 422)
	    (pcPurpose = "drawing")
	    (pcInst = dbCreateRect(pcCellView
		    list(pcLayer pcPurpose)
		    list((-0.37:-0.24)
			((0.52 + pcHorStretch30offset):(0.83 + finger_width4offset))
		    )
		))
	)
	if( (Fingers == 2)
	    then
	    (pcLayer = 399)
	    (pcPurpose = "drawing")
	    (pcInst = dbCreateRect(pcCellView
		    list(pcLayer pcPurpose)
		    list(((0.22 + Length3offset):(0.53 + finger_width4offset))
			((0.49 + Length3offset):(0.83 + finger_width4offset))
		    )
		))
	)
	(pcLayer = 399)
	(pcPurpose = "drawing")
	(pcLayer = 133)
	(pcPurpose = "label")
	(pcLayer = 133)
	(pcPurpose = "label")
	if( (Fingers > 2)
	    then
	    (pcLayer = 133)
	    (pcPurpose = "label")
	)
	if( (Fingers < 3)
	    then
	    (pcLayer = 133)
	    (pcPurpose = "label")
	)
	t
    )
)
