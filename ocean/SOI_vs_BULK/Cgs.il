simulator( 'spectre )
design(	 "UTSOI_model"  "Ids_VGS_@100mV_sc" "schematic")
resultsDir( "/home/pancha/simulation/Ids_VGS_@100mV/spectre/schematic" )
modelFile(
    '("/PDKs/LFOUNDRY2/PDK_LF150i_V2_0_0/analog/models/spectre/lf150.scs" "tt_hs")
    '("/PDKs/LFOUNDRY2/PDK_LF150i_V2_0_0/analog/models/spectre/lf150.scs" "tt_ll")
    '("/PDKs/LFOUNDRY2/PDK_LF150i_V2_0_0/analog/models/spectre/lf150.scs" "tt_na")
    '("/PDKs/LFOUNDRY2/PDK_LF150i_V2_0_0/analog/models/spectre/lf150.scs" "tt_3")
    '("/PDKs/LFOUNDRY2/PDK_LF150i_V2_0_0/analog/models/spectre/lf150.scs" "tt_5")
    '("/PDKs/LFOUNDRY2/PDK_LF150i_V2_0_0/analog/models/spectre/lf150.scs" "res_typ")
    '("/PDKs/LFOUNDRY2/PDK_LF150i_V2_0_0/analog/models/spectre/lf150.scs" "mim_typ")
    '("/PDKs/LFOUNDRY2/PDK_LF150i_V2_0_0/analog/models/spectre/lf150.scs" "bjt_t")
    '("/PDKs/LFOUNDRY2/PDK_LF150i_V2_0_0/analog/models/spectre/lf150.scs" "dio_t")
)
analysis('dc ?saveOppoint t  ?hysteresis t  ?param "VGS"
		?start "0"  ?stop "1.8"  )
desVar(	  "L1" 150n	)
desVar(	  "VDS" 1	)
desVar(	  "VGS" 1	)
envOption(
	'analysisOrder  list("dc")
)
temp( 27 )
paramAnalysis("VGS" ?values '(0 0.09 0.18 0.27 0.36 0.45 0.54 0.63 0.72 0.81 0.90 0.99 1.08 1.17 1.26 1.35 1.44 1.53 1.72 1.8 )
)
paramRun()
CGS = OP("/I0" "cgs")
plot( CGS ?expr '( "CGS" ) )
