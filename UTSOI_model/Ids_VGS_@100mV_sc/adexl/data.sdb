ADE simulation setup
Run mode: Single Run, Sweeps and Corners
Tests:
  UTSOI_model:Ids_VGS_@100mV_sc:1: UTSOI_model/Ids_VGS_@100mV_sc/schematic, simulator spectre
    Outputs: Cgs
Global variables:
  L1 = 150nm
  VDS = 1
  VGS = 1
