load(
    strcat(
            ddGetObjReadPath( ddGetObj( "lf150_passives" ))
            "/callbacks/callbacks.il"
    ) ; end strcat
) ; end load
