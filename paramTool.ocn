simulator( 'spectre )
design(	 "/home/pancha/simulation/LNA_impl1_sp_PAD_Imp_Trans/spectre/schematic/netlist/netlist")
resultsDir( "/home/pancha/simulation/LNA_impl1_sp_PAD_Imp_Trans/spectre/schematic" )
modelFile(
    '("/PDKs/LFOUNDRY2/PDK_LF150i_V2_0_0/analog/models/spectre/lf150.scs" "tt_hs")
    '("/PDKs/LFOUNDRY2/PDK_LF150i_V2_0_0/analog/models/spectre/lf150.scs" "tt_ll")
    '("/PDKs/LFOUNDRY2/PDK_LF150i_V2_0_0/analog/models/spectre/lf150.scs" "tt_na")
    '("/PDKs/LFOUNDRY2/PDK_LF150i_V2_0_0/analog/models/spectre/lf150.scs" "tt_3")
    '("/PDKs/LFOUNDRY2/PDK_LF150i_V2_0_0/analog/models/spectre/lf150.scs" "tt_5")
    '("/PDKs/LFOUNDRY2/PDK_LF150i_V2_0_0/analog/models/spectre/lf150.scs" "res_typ")
    '("/PDKs/LFOUNDRY2/PDK_LF150i_V2_0_0/analog/models/spectre/lf150.scs" "mim_typ")
    '("/PDKs/LFOUNDRY2/PDK_LF150i_V2_0_0/analog/models/spectre/lf150.scs" "bjt_t")
    '("/PDKs/LFOUNDRY2/PDK_LF150i_V2_0_0/analog/models/spectre/lf150.scs" "dio_t")
)
analysis('sp ?ports list("/PORT_INP" "/PORT_OUT_I")  ?start "2.3G"  ?stop "2.5G"
		?dec "200"  ?donoise "yes"  ?oprobe "/PORT_OUT_I"  ?iprobe "/PORT_INP"  )
desVar(	  "Cext" 140f	)
desVar(	  "Lind" 10.6n	)
desVar(	  "C0" 675f	)
desVar(	  "C1" 100p	)
desVar(	  "Cdecap" 1p	)
desVar(	  "CdecapIN" 1p	)
desVar(	  "CdecapMatch" 1p	)
desVar(	  "frf1" 2.4G	)
desVar(	  "IBIAS" 1.2m	)
desVar(	  "L1" 150n	)
desVar(	  "Lbias" 250n	)
desVar(	  "prf" -30	)
desVar(	  "RdcpI" 10K	)
desVar(	  "RdcpQ" 10K	)
desVar(	  "Rmatch" 300	)
desVar(	  "Rout" 300	)
desVar(	  "vdsBias" 450m	)
desVar(	  "vdsn" 450m	)
desVar(	  "vgsBias" 578m	)
desVar(	  "vgsn" 456m	)
desVar(	  "Wbias" 8u	)
desVar(	  "Wf1" 16u	)
envOption(
	'analysisOrder  list("sp")
)
temp( 27 )
paramAnalysis("Lind" ?values '(1e-09 1.48979591836735e-09 1.97959183673469e-09 2.46938775510204e-09 2.95918367346939e-09 3.44897959183673e-09 3.93877551020408e-09 4.42857142857143e-09 4.91836734693878e-09 5.40816326530612e-09 5.89795918367347e-09 6.38775510204082e-09 6.87755102040816e-09 7.36734693877551e-09 7.85714285714286e-09 8.34693877551021e-09 8.83673469387755e-09 9.3265306122449e-09 9.81632653061224e-09 1.03061224489796e-08 1.07959183673469e-08 1.12857142857143e-08 1.17755102040816e-08 1.2265306122449e-08 1.27551020408163e-08 1.32448979591837e-08 1.3734693877551e-08 1.42244897959184e-08 1.47142857142857e-08 1.5204081632653e-08 1.56938775510204e-08 1.61836734693877e-08 1.66734693877551e-08 1.71632653061224e-08 1.76530612244898e-08 1.81428571428571e-08 1.86326530612245e-08 1.91224489795918e-08 1.96122448979592e-08 2.01020408163265e-08 2.05918367346939e-08 2.10816326530612e-08 2.15714285714285e-08 2.20612244897959e-08 2.25510204081632e-08 2.30408163265306e-08 2.35306122448979e-08 2.40204081632653e-08 2.45102040816326e-08 2.5e-08 )
)
paramRun()
S11\  = spm('sp 1 1)
plot( S11\  ?expr '( "S11 " ) )
