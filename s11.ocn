simulator( 'spectre )
design(	 "/home/pancha/simulation/LNA_impl1_inp_matching/spectre/schematic/netlist/netlist")
resultsDir( "/home/pancha/simulation/LNA_impl1_inp_matching/spectre/schematic" )
modelFile(
    '("/PDKs/LFOUNDRY2/PDK_LF150i_V2_0_0/analog/models/spectre/lf150.scs" "tt_hs")
    '("/PDKs/LFOUNDRY2/PDK_LF150i_V2_0_0/analog/models/spectre/lf150.scs" "tt_ll")
    '("/PDKs/LFOUNDRY2/PDK_LF150i_V2_0_0/analog/models/spectre/lf150.scs" "tt_na")
    '("/PDKs/LFOUNDRY2/PDK_LF150i_V2_0_0/analog/models/spectre/lf150.scs" "tt_3")
    '("/PDKs/LFOUNDRY2/PDK_LF150i_V2_0_0/analog/models/spectre/lf150.scs" "tt_5")
    '("/PDKs/LFOUNDRY2/PDK_LF150i_V2_0_0/analog/models/spectre/lf150.scs" "res_typ")
    '("/PDKs/LFOUNDRY2/PDK_LF150i_V2_0_0/analog/models/spectre/lf150.scs" "mim_typ")
    '("/PDKs/LFOUNDRY2/PDK_LF150i_V2_0_0/analog/models/spectre/lf150.scs" "bjt_t")
    '("/PDKs/LFOUNDRY2/PDK_LF150i_V2_0_0/analog/models/spectre/lf150.scs" "dio_t")
)
analysis('sp ?ports list("/PORT0" "/PORT1")  ?start "1G"  ?stop "5G"
		?donoise "yes"  ?oprobe "/PORT1"  ?iprobe "/PORT0"  )
desVar(	  "Rmatch" 50	)
desVar(	  "amp1" -20	)
desVar(	  "C1" 60p	)
desVar(	  "freq1" 2.4G	)
desVar(	  "C0" 550f	)
desVar(	  "cds1" 11.35f	)
desVar(	  "cds2" 11.35f	)
desVar(	  "cgd1" 17.71f	)
desVar(	  "cgd2" 17.71f	)
desVar(	  "cgs1" 47.72f	)
desVar(	  "cgs2" 47.72f	)
desVar(	  "gm1" 12.516m	)
desVar(	  "gm2" 12.516m	)
desVar(	  "rds1" 2547.19	)
desVar(	  "rds2" 2547.19	)
desVar(	  "RL" 500	)
desVar(	  "Vac" 1	)
envOption(
	'analysisOrder  list("sp")
)
temp( 27 )
paramAnalysis("Rmatch" ?values '(20 23.9195979899498 27.8391959798995 31.7587939698493 35.678391959799 39.5979899497488 43.5175879396985 47.4371859296483 51.356783919598 55.2763819095478 59.1959798994975 63.1155778894473 67.035175879397 70.9547738693468 74.8743718592965 78.7939698492463 82.713567839196 86.6331658291458 90.5527638190955 94.4723618090453 98.391959798995 102.311557788945 106.231155778895 110.150753768844 114.070351758794 117.989949748744 121.909547738694 125.829145728643 129.748743718593 133.668341708543 137.587939698493 141.507537688442 145.427135678392 149.346733668342 153.266331658292 157.185929648241 161.105527638191 165.025125628141 168.944723618091 172.86432160804 176.78391959799 180.70351758794 184.62311557789 188.542713567839 192.462311557789 196.381909547739 200.301507537689 204.221105527638 208.140703517588 212.060301507538 215.979899497488 219.899497487437 223.819095477387 227.738693467337 231.658291457287 235.577889447236 239.497487437186 243.417085427136 247.336683417086 251.256281407035 255.175879396985 259.095477386935 263.015075376885 266.934673366834 270.854271356784 274.773869346734 278.693467336684 282.613065326633 286.532663316583 290.452261306533 294.371859296483 298.291457286432 302.211055276382 306.130653266332 310.050251256282 313.969849246231 317.889447236181 321.809045226131 325.728643216081 329.64824120603 333.56783919598 337.48743718593 341.40703517588 345.326633165829 349.246231155779 353.165829145729 357.085427135679 361.005025125628 364.924623115578 368.844221105528 372.763819095478 376.683417085427 380.603015075377 384.522613065327 388.442211055277 392.361809045226 396.281407035176 400.201005025126 404.120603015076 408.040201005025 411.959798994975 415.879396984925 419.798994974875 423.718592964824 427.638190954774 431.557788944724 435.477386934674 439.396984924623 443.316582914573 447.236180904523 451.155778894473 455.075376884422 458.994974874372 462.914572864322 466.834170854272 470.753768844221 474.673366834171 478.592964824121 482.512562814071 486.43216080402 490.35175879397 494.27135678392 498.19095477387 502.110552763819 506.030150753769 509.949748743719 513.869346733669 517.788944723618 521.708542713568 525.628140703518 529.547738693467 533.467336683417 537.386934673367 541.306532663316 545.226130653266 549.145728643216 553.065326633165 556.984924623115 560.904522613065 564.824120603015 568.743718592964 572.663316582914 576.582914572864 580.502512562813 584.422110552763 588.341708542713 592.261306532662 596.180904522612 600.100502512562 604.020100502511 607.939698492461 611.859296482411 615.778894472361 619.69849246231 623.61809045226 627.53768844221 631.457286432159 635.376884422109 639.296482412059 643.216080402008 647.135678391958 651.055276381908 654.974874371857 658.894472361807 662.814070351757 666.733668341707 670.653266331656 674.572864321606 678.492462311556 682.412060301505 686.331658291455 690.251256281405 694.170854271354 698.090452261304 702.010050251254 705.929648241203 709.849246231153 713.768844221103 717.688442211053 721.608040201002 725.527638190952 729.447236180902 733.366834170851 737.286432160801 741.206030150751 745.1256281407 749.04522613065 752.9648241206 756.88442211055 760.804020100499 764.723618090449 768.643216080399 772.562814070348 776.482412060298 780.402010050248 784.321608040197 788.241206030147 792.160804020097 796.080402010046 800 )
)
paramRun()
S11\ dB20 = db(spm('sp 1 1))
plot( S11\ dB20 ?expr '( "S11 dB20" ) )
