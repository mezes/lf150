load(
    strcat(
            ddGetObjReadPath( ddGetObj( "lf150_top" ))
            "/callbacks/callbacks.il"
    ) ; end strcat
) ; end load
